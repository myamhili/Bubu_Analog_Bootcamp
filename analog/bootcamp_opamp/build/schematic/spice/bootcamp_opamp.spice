** sch_path: /mnt/c/Users/Hyun/Documents/GitHub/Bubu_Analog_Bootcamp/analog/bootcamp_opamp/schematics/bootcamp_opamp.sch
**.subckt bootcamp_opamp vdpwr vout vin- vin+ vbn vgnd
*.iopin vdpwr
*.opin vout
*.ipin vin-
*.ipin vin+
*.ipin vbn
*.iopin vgnd
X1 vdpwr vout vin- vin+ vbn vgnd opamp_two_stage
**.ends

* expanding   symbol:  opamp_two_stage.sym # of pins=6
** sym_path: /mnt/c/Users/Hyun/Documents/GitHub/Bubu_Analog_Bootcamp/analog/bootcamp_opamp/build/schematic/opamp_two_stage.sym
** sch_path: /mnt/c/Users/Hyun/Documents/GitHub/Bubu_Analog_Bootcamp/analog/bootcamp_opamp/build/schematic/opamp_two_stage.sch
.subckt opamp_two_stage VDD VOUT VIN_N VIN_P VBIAS VSS
*.ipin VIN_P
*.ipin VIN_N
*.iopin VDD
*.iopin VSS
*.ipin VBIAS
*.opin VOUT
XM1 net2 VIN_N net1 VSS sky130_fd_pr__nfet_01v8 L=0.500 W=0.420 nf=1 ad='int((nf+1)/2) * W/nf * 0.29' as='int((nf+2)/2) * W/nf * 0.29'
+ pd='2*int((nf+1)/2) * (W/nf + 0.29)' ps='2*int((nf+2)/2) * (W/nf + 0.29)' nrd='0.29 / W' nrs='0.29 / W' sa=0 sb=0 sd=0 mult=1 m=1
XM2 net3 VIN_P net1 VSS sky130_fd_pr__nfet_01v8 L=0.500 W=0.420 nf=1 ad='int((nf+1)/2) * W/nf * 0.29' as='int((nf+2)/2) * W/nf * 0.29'
+ pd='2*int((nf+1)/2) * (W/nf + 0.29)' ps='2*int((nf+2)/2) * (W/nf + 0.29)' nrd='0.29 / W' nrs='0.29 / W' sa=0 sb=0 sd=0 mult=1 m=1
XM3 net2 net2 VDD VDD sky130_fd_pr__pfet_01v8 L=1.000 W=0.893 nf=1 ad='int((nf+1)/2) * W/nf * 0.29' as='int((nf+2)/2) * W/nf * 0.29'
+ pd='2*int((nf+1)/2) * (W/nf + 0.29)' ps='2*int((nf+2)/2) * (W/nf + 0.29)' nrd='0.29 / W' nrs='0.29 / W' sa=0 sb=0 sd=0 mult=1 m=1
XM4 net3 net2 VDD VDD sky130_fd_pr__pfet_01v8 L=1.000 W=0.893 nf=1 ad='int((nf+1)/2) * W/nf * 0.29' as='int((nf+2)/2) * W/nf * 0.29'
+ pd='2*int((nf+1)/2) * (W/nf + 0.29)' ps='2*int((nf+2)/2) * (W/nf + 0.29)' nrd='0.29 / W' nrs='0.29 / W' sa=0 sb=0 sd=0 mult=1 m=1
XM5 net1 VBIAS VSS VSS sky130_fd_pr__nfet_01v8 L=1.000 W=0.463 nf=1 ad='int((nf+1)/2) * W/nf * 0.29' as='int((nf+2)/2) * W/nf * 0.29'
+ pd='2*int((nf+1)/2) * (W/nf + 0.29)' ps='2*int((nf+2)/2) * (W/nf + 0.29)' nrd='0.29 / W' nrs='0.29 / W' sa=0 sb=0 sd=0 mult=1 m=1
XM6 VOUT net3 VDD VDD sky130_fd_pr__pfet_01v8 L=0.500 W=5.238 nf=1 ad='int((nf+1)/2) * W/nf * 0.29' as='int((nf+2)/2) * W/nf * 0.29'
+ pd='2*int((nf+1)/2) * (W/nf + 0.29)' ps='2*int((nf+2)/2) * (W/nf + 0.29)' nrd='0.29 / W' nrs='0.29 / W' sa=0 sb=0 sd=0 mult=1 m=1
XC1 VOUT net3 sky130_fd_pr__cap_mim_m3_1 W=10 L=12.5 MF=1 m=1
XM7 VOUT VBIAS VSS VSS sky130_fd_pr__nfet_01v8 L=1.000 W=4.829 nf=1 ad='int((nf+1)/2) * W/nf * 0.29' as='int((nf+2)/2) * W/nf * 0.29'
+ pd='2*int((nf+1)/2) * (W/nf + 0.29)' ps='2*int((nf+2)/2) * (W/nf + 0.29)' nrd='0.29 / W' nrs='0.29 / W' sa=0 sb=0 sd=0 mult=1 m=1
.ends

.GLOBAL VDD
.GLOBAL VSS
.end
